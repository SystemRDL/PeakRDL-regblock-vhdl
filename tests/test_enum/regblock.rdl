addrmap top {
    enum my_enum {
        val_1 = 3 {name = "Value 1";};
        val_2 = 4 {desc = "Second value";};
        val_3 = 11 {desc = "Third value";};
    };
    reg {
        field {
            encode = my_enum;
            sw=rw; hw=na;
        } f[3:0] = my_enum::val_2;
    } r0;
};
