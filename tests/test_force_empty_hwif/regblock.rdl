addrmap regblock {
    default sw = rw;
    default hw = na;

    reg {
        field {} f[31:0] = 0;
    } my_reg;
};
