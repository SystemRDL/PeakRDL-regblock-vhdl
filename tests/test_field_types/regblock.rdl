addrmap top {
    default regwidth = 8;

    // All the valid combinations from Table 12
    // Test multi-bit and single-bit fields
    reg {
        // Storage element
        default sw=rw;
        default hw=rw;
        default we;
        field {} f1[7] = 10;
        field {} f2[1] = 0;
    } r1;

    reg {
        // Storage element
        default sw=rw;
        default hw=r;
        field {} f1[7] = 20;
        field {} f2[1] = 1;
    } r2;

    reg {
        // Storage element
        default sw=rw;
        default hw=w;
        default wel;
        field {} f1[7] = 30;
        field {} f2[1] = 0;
    } r3;

    reg {
        // Storage element
        default sw=rw;
        default hw=na;
        field {} f1[7] = 40;
        field {} f2[1] = 1;
    } r4;

    reg {
        // Storage element
        default sw=r;
        default hw=rw;
        default we;
        field {} f1[7] = 50;
        field {} f2[1] = 0;
    } r5;

    reg {
        // Wire/Bus - constant value
        default sw=r;
        default hw=r;
        field {} f1[7] = 60;
        field {} f2[1] = 1;
    } r6;

    reg {
        // Wire/Bus - hardware assigns value
        default sw=r;
        default hw=w;
        field {} f1[7];
        field {} f2[1];
    } r7;

    reg {
        // Wire/Bus - constant value
        default sw=r;
        default hw=na;
        field {} f1[7] = 80;
        field {} f2[1] = 0;
    } r8;

    reg {
        // Storage element
        default sw=w;
        default hw=rw;
        default we;
        field {} f1[7] = 90;
        field {} f2[1] = 1;
    } r9;

    reg {
        // Storage element
        default sw=w;
        default hw=r;
        field {} f1[7] = 100;
        field {} f2[1] = 0;
    } r10;
};
